ADE simulation setup
Test asif_NOR_sim_1: asif/NOR_sim/schematic, simulator spectre
  Models: /home/cadence/tech/gpdk045_v_6_0/gpdk045/../models/spectre/gpdk045.scs[mc]
  Temperature: 27
  Analysis dc: sweep /V0.dc start=0 stop=1.8 (saves the operating point)
  Signals: /Va as a, /Vb as b, /Vout as y
Run mode: Single Run, Sweeps and Corners
