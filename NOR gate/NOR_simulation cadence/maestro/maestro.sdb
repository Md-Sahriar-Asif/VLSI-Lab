ADE simulation setup
Run mode: Single Run, Sweeps and Corners
Tests:
  asif_NOR_sim_1: asif/NOR_sim/schematic, simulator spectre
    Outputs: a; b; y
